*** SPICE deck for cell cmos-inverter{lay} from library Digital-Circuit-CMOS-Design
*** Created on Fri May 08, 2026 10:37:47
*** Last revised on Mon May 18, 2026 21:57:12
*** Written on Mon May 18, 2026 21:57:23 by Electric VLSI Design System, version 9.08
*** Layout tech: mocmos, foundry MOSIS
*** UC SPICE *** , MIN_RESIST 4.0, MIN_CAPAC 0.1FF

*** TOP LEVEL CELL: cmos-inverter{lay}
Mnmos_1 Vout Vin 0 0 NMOS L=0.4U W=2U AS=6.6P AD=3.9P PS=16.6U PD=8.6U
Mpmos_0 Vout Vin vdd vdd PMOS L=0.4U W=4U AS=9.2P AD=3.9P PS=20.6U PD=8.6U

* Spice Code nodes in cell cell 'cmos-inverter{lay}'
vdd vdd 0 DC 5
vgnd gnd 0 DC 0
vin vin 0 pulse (0 5 0 1n 1n 10n 20n)
.include "C:\C5_models.txt"
.tran 1n 100n
.END
